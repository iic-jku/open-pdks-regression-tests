* Extracted by KLayout with GF180MCU LVS runset on : 18/08/2026 14:21

* cell gf180_pfet_05v0
* pin B
* pin D
* pin G
* pin S
.SUBCKT gf180_pfet_05v0 B D G S
* device instance $1 r0 *1 2.39,1.71 pfet_05v0
M$1 S G D B pfet_05v0 L=0.5U W=0.42U AS=0.3326P AD=0.3326P PS=2.42U PD=2.42U
.ENDS gf180_pfet_05v0
