* Extracted by KLayout with GF180MCU LVS runset on : 18/08/2026 14:06

* cell gf180_pfet_03v3
* pin B
* pin D
* pin G
* pin S
.SUBCKT gf180_pfet_03v3 B D G S
* device instance $1 r0 *1 2.355,18.005 pfet_03v3
M$1 S G D B pfet_03v3 L=0.28U W=0.42U AS=0.2822P AD=0.2822P PS=2.18U PD=2.18U
.ENDS gf180_pfet_03v3
