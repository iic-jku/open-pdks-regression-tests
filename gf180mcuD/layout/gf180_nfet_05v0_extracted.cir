* Extracted by KLayout with GF180MCU LVS runset on : 18/08/2026 15:24

* cell gf180_nfet_05v0
* pin B
* pin D
* pin G
* pin S
.SUBCKT gf180_nfet_05v0 B D G S
* device instance $1 r0 *1 1.5,0.915 nfet_05v0
M$1 S G D B nfet_05v0 L=0.7U W=0.42U AS=0.315P AD=0.315P PS=2.34U PD=2.34U
.ENDS gf180_nfet_05v0
