* Extracted by KLayout with GF180MCU LVS runset on : 18/08/2026 15:19

* cell gf180_nfet_06v0
* pin B
* pin D
* pin G
* pin S
.SUBCKT gf180_nfet_06v0 B D G S
* device instance $1 r0 *1 1.505,0.925 nfet_06v0
M$1 S G D B nfet_06v0 L=0.7U W=0.42U AS=0.315P AD=0.315P PS=2.34U PD=2.34U
.ENDS gf180_nfet_06v0
