*********************************************************
*** NGSPICE file created by KLayout-PEX 0.3.15
*** -----------------------------------------------------
***     Extraction Engine: KPEX/FasterCap
***     Technology: ihp_sg13g2
***     Date: 2026-09-04 11:28:51
*********************************************************

.SUBCKT sidewall_m1_s3p2
CCext_0_1 VSUBS \$2 4.62657f
CCext_0_2 VSUBS \$3 4.61997f
CCext_1_2 \$2 \$3 423.663a
CCext_1_1 \$2 VSUBS 233.177a
CCext_2_2 \$3 VSUBS 246.067a
RRext_FC_GND_GND FC_GND GND 0 PEX_RES
RRext_VSUBS_GND VSUBS GND 0 PEX_RES
.ENDS sidewall_m1_s3p2
