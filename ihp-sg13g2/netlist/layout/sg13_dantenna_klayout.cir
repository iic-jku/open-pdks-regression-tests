* Extracted by KLayout with SG13G2 LVS runset on : 23/07/2026 16:41

.SUBCKT sg13_dantenna B C
D$1 B C dantenna A=0.6084p P=3.12u m=1
.ENDS sg13_dantenna
