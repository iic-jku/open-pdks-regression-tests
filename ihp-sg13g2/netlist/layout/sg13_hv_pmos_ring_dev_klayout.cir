* Extracted by KLayout with SG13G2 LVS runset on : 23/07/2026 16:44

.SUBCKT sg13_hv_pmos_ring_dev B D G S
M$1 S G D B sg13_hv_pmos L=0.4u W=0.3u AS=0.102p AD=0.102p PS=1.28u PD=1.28u
+ rfmode=0
.ENDS sg13_hv_pmos_ring_dev
