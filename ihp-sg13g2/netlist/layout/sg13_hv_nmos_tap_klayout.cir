* Extracted by KLayout with SG13G2 LVS runset on : 23/07/2026 16:43

.SUBCKT sg13_hv_nmos_tap B D G S
M$1 S G D B sg13_hv_nmos L=0.45u W=0.3u AS=0.102p AD=0.102p PS=1.28u PD=1.28u
+ rfmode=0
.ENDS sg13_hv_nmos_tap
