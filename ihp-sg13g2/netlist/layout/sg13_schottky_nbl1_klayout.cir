* Extracted by KLayout with SG13G2 LVS runset on : 23/07/2026 16:53

.SUBCKT sg13_schottky_nbl1 A B C
D$1 A C B schottky_nbl1 m=1
.ENDS sg13_schottky_nbl1
