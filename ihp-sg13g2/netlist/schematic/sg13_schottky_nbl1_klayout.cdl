** sch_path: /foss/designs/open-pdks-regression-tests/ihp-sg13g2/schematic/xschem/sg13_schottky_nbl1.sch
.subckt sg13_schottky_nbl1 C A B
*.PININFO C:B A:B B:B
DD1 A C B schottky_nbl1
.ends
