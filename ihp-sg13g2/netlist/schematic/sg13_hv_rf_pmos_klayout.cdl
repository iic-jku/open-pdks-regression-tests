** sch_path: /foss/designs/open-pdks-regression-tests/ihp-sg13g2/schematic/xschem/sg13_hv_rf_pmos.sch
.subckt sg13_hv_rf_pmos D S G B
*.PININFO D:B S:B G:B B:B
MM1 S G D B rfpmoshv w=1.0u l=0.72u ng=1
.ends
