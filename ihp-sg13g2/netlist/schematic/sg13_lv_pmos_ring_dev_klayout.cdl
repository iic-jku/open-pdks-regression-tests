** sch_path: /foss/designs/open-pdks-regression-tests/ihp-sg13g2/schematic/xschem/sg13_lv_pmos_ring_dev.sch
.subckt sg13_lv_pmos_ring_dev D S G B
*.PININFO D:B S:B G:B B:B
MM1 D G S B sg13_lv_pmos w=0.15u l=0.13u ng=1
.ends
