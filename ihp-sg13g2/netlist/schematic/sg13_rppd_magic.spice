** sch_path: /foss/designs/open-pdks-regression-tests/ihp-sg13g2/schematic/xschem/sg13_rppd.sch
.subckt sg13_rppd R0 R1
*.PININFO R0:B R1:B
XR1 R0 R1 sub! rppd w=0.5e-6 l=0.5e-6 m=1 b=0 mm_ok=1
.ends
