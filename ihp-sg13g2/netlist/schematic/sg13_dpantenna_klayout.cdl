** sch_path: /foss/designs/open-pdks-regression-tests/ihp-sg13g2/schematic/xschem/sg13_dpantenna.sch
.subckt sg13_dpantenna A B
*.PININFO A:B B:B
DD1 A B dpantenna l=0.78u w=0.78u
.ends
