** sch_path: /foss/designs/open-pdks-regression-tests/ihp-sg13g2/schematic/xschem/sg13_hv_pmos_ring_pcell.sch
.subckt sg13_hv_pmos_ring_pcell D S G B
*.PININFO D:B S:B G:B B:B
MM2 D G S B sg13_hv_pmos w=0.3u l=0.4u ng=1
.ends
