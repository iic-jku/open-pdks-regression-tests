** sch_path: /foss/designs/open-pdks-regression-tests/ihp-sg13g2/schematic/xschem/sg13_hv_nmos_tap.sch
.subckt sg13_hv_nmos_tap D S G B
*.PININFO D:B S:B G:B B:B
XM1 D G S B sg13_hv_nmos w=0.3u l=0.45u ng=1 m=1 mm_ok=1
.ends
