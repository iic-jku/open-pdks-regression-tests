** sch_path: /foss/designs/open-pdks-regression-tests/ihp-sg13g2/schematic/xschem/sg13_lv_rf_nmos.sch
.subckt sg13_lv_rf_nmos D S G B
*.PININFO D:B S:B G:B B:B
MM1 D G S B rfnmos w=1.0u l=0.72u ng=1
.ends
