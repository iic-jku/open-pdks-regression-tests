* PEX produced on Thu Jul 23 04:40:00 PM CEST 2026 using /foss/tools/sak/sak-pex.sh with m=2 and s=1
* NGSPICE file created from sg13_combined_cmim_ontop_wo_rfcmim_pex.ext - technology: ihp-sg13g2

.subckt sg13_combined_cmim_ontop_wo_rfcmim_pex G VDD VSS
X0 a_554_348# G VSS VSS sg13_lv_nmos ad=0.345p pd=2.69u as=0.345p ps=2.69u w=1u l=0.72u
X1 dw_2768_2744# G VSS VSS sg13_hv_nmos ad=0.345p pd=2.69u as=0.345p ps=2.69u w=1u l=0.72u
X2 VSS dw_2768_2744# VSS schottky_nbl1 l=1.2u w=2.655u
X3 a_136_2612# a_554_348# cap_cmim l=20u w=20u
X4 VSS a_2910_379# dantenna l=0.78u w=0.78u
X5 a_832_2612# dw_2768_2744# VSS rsil l=0.5u w=0.5u
X6 a_136_2612# a_414_2612# VSS rhigh l=0.96u w=0.5u
X7 VSS VSS a_2910_379# VSS sg13_hv_nmos ad=0.102p pd=1.28u as=0.102p ps=1.28u w=0.3u l=0.45u
X8 a_2910_379# VDD VDD VDD sg13_hv_pmos ad=0.102p pd=1.28u as=0.102p ps=1.28u w=0.3u l=0.45u
X9 a_414_2612# a_832_2612# VSS rppd l=0.5u w=0.5u
X10 VSS VSS a_2910_379# VSS sg13_lv_nmos ad=0.1005p pd=1.34u as=0.1005p ps=1.34u w=0.15u l=0.45u
X11 a_2910_379# VDD dpantenna l=0.78u w=0.78u
X12 VDD G a_554_348# VDD sg13_lv_pmos ad=0.345p pd=2.69u as=0.345p ps=2.69u w=1u l=0.72u
X13 a_2910_379# VDD VDD VDD sg13_lv_pmos ad=0.1005p pd=1.34u as=0.1005p ps=1.34u w=0.15u l=0.45u
X14 VDD G dw_2768_2744# VDD sg13_hv_pmos ad=0.345p pd=2.69u as=0.345p ps=2.69u w=1u l=0.72u
C0 dw_2768_2744# a_554_348# 0.62961f
C1 a_222_2612# a_414_2612# 0.01184f
C2 G a_554_348# 1.62443f
C3 a_554_348# a_414_2612# 0.0231f
C4 a_554_348# VDD 1.56381f
C5 dw_2768_2744# a_136_2612# 0.01068f
C6 dw_2768_2744# a_832_2612# 0.0277f
C7 a_136_2612# G 0.01235f
C8 a_136_2612# a_414_2612# 0.01766f
C9 a_832_2612# a_414_2612# 0.02132f
C10 a_2910_379# VDD 0.80967f
C11 a_136_2612# VDD 0.02439f
C12 a_136_2612# a_222_2612# 0.01657f
C13 a_2910_379# a_554_348# 0.20112f
C14 a_832_2612# a_554_348# 0.02434f
C15 a_136_2612# a_554_348# 1.30831f
C16 dw_2768_2744# G 1.15252f
C17 dw_2768_2744# VDD 0.35721f
C18 dw_2768_2744# a_1134_2612# 0.01152f
C19 G VDD 4.03849f
C20 a_554_348# VSS 12.984f
C21 a_2910_379# VSS 1.21656f
C22 a_832_2612# VSS 0.31011f
C23 a_414_2612# VSS 0.34892f
C24 a_136_2612# VSS 0.06414f
C25 dw_2768_2744# VSS 4.59056f
.ends
