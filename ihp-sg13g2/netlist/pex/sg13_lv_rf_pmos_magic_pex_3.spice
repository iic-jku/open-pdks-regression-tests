* PEX produced on Thu Jul 23 04:51:00 PM CEST 2026 using /foss/tools/sak/sak-pex.sh with m=3 and s=1 (extresist threshold=10000 mOhm, minres=1000 mOhm, mindelay=1 ps)
* NGSPICE file created from sg13_lv_rf_pmos_pex.ext - technology: ihp-sg13g2

.subckt sg13_lv_rf_pmos_pex S D G B
X0 D G S B sg13_lv_pmos ad=0.345p pd=2.69u as=0.345p ps=2.69u w=1u l=0.72u
C0 B S 0.02485f
C1 D S 0.08f
C2 S G 0.30632f
C3 D B 0.02485f
C4 B G 1.27731f
C5 D G 0.30632f
C6 D sub 0.05665f
C7 S sub 0.05665f
C8 B sub 0.48287f
.ends
