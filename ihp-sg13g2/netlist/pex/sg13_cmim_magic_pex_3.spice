* PEX produced on Thu Jul 23 04:38:38 PM CEST 2026 using /foss/tools/sak/sak-pex.sh with m=3 and s=1 (extresist threshold=10000 mOhm, minres=1000 mOhm, mindelay=1 ps)
* NGSPICE file created from sg13_cmim_pex.ext - technology: ihp-sg13g2

.subckt sg13_cmim_pex C1 C0
X0 C0 C1 cap_cmim l=7u w=7u
C0 C1 C0 0.4133f
C1 C1 w_0_0# 2.28434f
.ends
