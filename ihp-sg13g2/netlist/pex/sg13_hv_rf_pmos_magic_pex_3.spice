* PEX produced on Thu Jul 23 04:46:37 PM CEST 2026 using /foss/tools/sak/sak-pex.sh with m=3 and s=1 (extresist threshold=10000 mOhm, minres=1000 mOhm, mindelay=1 ps)
* NGSPICE file created from sg13_hv_rf_pmos_pex.ext - technology: ihp-sg13g2

.subckt sg13_hv_rf_pmos_pex B G D S
X0 D G S B sg13_hv_pmos ad=0.345p pd=2.69u as=0.345p ps=2.69u w=1u l=0.72u
C0 D B 0.02748f
C1 B G 1.28855f
C2 D G 0.30633f
C3 B S 0.02748f
C4 D S 0.08001f
C5 S G 0.30633f
C6 D sub 0.0484f
C7 S sub 0.0484f
C8 B sub 0.40489f
.ends
