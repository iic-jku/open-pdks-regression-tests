* PEX produced on Thu Jul 23 04:40:00 PM CEST 2026 using /foss/tools/sak/sak-pex.sh with m=3 and s=1 (extresist threshold=10000 mOhm, minres=1000 mOhm, mindelay=1 ps)
* NGSPICE file created from sg13_combined_cmim_ontop_wo_rfcmim_pex.ext - technology: ihp-sg13g2

.subckt sg13_combined_cmim_ontop_wo_rfcmim_pex G VDD VSS
X0 a_554_348# G VSS.t2 VSS.t0 sg13_lv_nmos ad=0.345p pd=2.69u as=0.345p ps=2.69u w=1u l=0.72u
X1 dw_2768_2744# G VSS.t1 VSS.t0 sg13_hv_nmos ad=0.345p pd=2.69u as=0.345p ps=2.69u w=1u l=0.72u
X2 VSS.t4 dw_2768_2744# VSS schottky_nbl1 l=1.2u w=2.655u
X3 a_136_2612# a_554_348# cap_cmim l=20u w=20u
X4 VSS.t9 a_2910_379# dantenna l=0.78u w=0.78u
X5 a_832_2612# dw_2768_2744# VSS.t12 rsil l=0.5u w=0.5u
X6 a_136_2612# a_414_2612# VSS.t11 rhigh l=0.96u w=0.5u
X7 VSS.t5 VSS.t5 a_2910_379# VSS.t6 sg13_hv_nmos ad=0.102p pd=1.28u as=0.102p ps=1.28u w=0.3u l=0.45u
X8 a_2910_379# VDD VDD VDD sg13_hv_pmos ad=0.102p pd=1.28u as=0.102p ps=1.28u w=0.3u l=0.45u
X9 a_414_2612# a_832_2612# VSS.t3 rppd l=0.5u w=0.5u
X10 VSS.t5 VSS.t5 a_2910_379# VSS.t7 sg13_lv_nmos ad=0.1005p pd=1.34u as=0.1005p ps=1.34u w=0.15u l=0.45u
X11 a_2910_379# VDD dpantenna l=0.78u w=0.78u
X12 VDD G a_554_348# VDD sg13_lv_pmos ad=0.345p pd=2.69u as=0.345p ps=2.69u w=1u l=0.72u
X13 a_2910_379# VDD VDD VDD sg13_lv_pmos ad=0.1005p pd=1.34u as=0.1005p ps=1.34u w=0.15u l=0.45u
X14 VDD G dw_2768_2744# VDD sg13_hv_pmos ad=0.345p pd=2.69u as=0.345p ps=2.69u w=1u l=0.72u
R0 VSS.n28 VSS.n11 50534.7
R1 VSS.t12 VSS.n28 16852.7
R2 VSS.n25 VSS.n20 6810
R3 VSS.n26 VSS.n25 5385.83
R4 VSS.n28 VSS.n21 4147.25
R5 VSS.n5 VSS.n6 2.58433
R6 VSS.t9 VSS.n7 946.434
R7 VSS.n26 VSS.n6 3336.62
R8 VSS.n15 VSS.n21 3240.56
R9 VSS.n27 VSS.t9 1887.42
R10 VSS.n25 VSS.n21 1775.89
R11 VSS.t12 VSS.n20 1617.14
R12 VSS.n5 VSS.n7 0.00500194
R13 VSS.n30 VSS.t12 232.076
R14 VSS.n14 VSS.t6 50.1815
R15 VSS.n6 VSS.n20 2892.24
R16 VSS.n13 VSS.n11 0.00273097
R17 VSS.n11 VSS.t7 60.3922
R18 VSS.n14 VSS.n13 0.00135766
R19 VSS.n30 VSS.t3 36.793
R20 VSS.n1 VSS.t11 37.2461
R21 VSS.n7 VSS.n15 0.0983759
R22 VSS.n4 VSS.n18 12.6806
R23 VSS.n0 VSS.n3 1.08734
R24 VSS.n0 VSS.n2 1.08734
R25 VSS.n0 VSS.n1 1.30972
R26 VSS.n29 VSS.n0 8.50172
R27 VSS.t11 VSS.n10 16.2741
R28 VSS.n29 VSS.t3 12.7363
R29 VSS.n5 VSS.t4 10.8197
R30 VSS.n19 VSS.n4 12.6812
R31 VSS.n2 VSS.n10 6.32988
R32 VSS.n3 VSS.t0 6.32988
R33 VSS.n24 VSS.n16 9.01307
R34 VSS.n27 VSS.n8 2.43083
R35 VSS.n1 VSS.n31 1.31045
R36 VSS.n31 VSS.n10 8.5005
R37 VSS.n23 VSS.n9 0.696532
R38 VSS.t0 VSS.n17 6.35185
R39 VSS.n2 VSS.n17 12.6806
R40 VSS.n3 VSS.n18 12.6806
R41 VSS.n29 VSS.n19 6.35185
R42 VSS.n8 VSS.n13 0.00174419
R43 VSS.t2 VSS.n31 5.28542
R44 VSS.n33 VSS.n32 4.5005
R45 VSS.n30 VSS.n0 1.88972
R46 VSS.n13 VSS.n22 4.18774
R47 VSS.n4 VSS.n0 1.08734
R48 VSS.n33 VSS.n16 2.91368
R49 VSS.n13 VSS.n23 2.30362
R50 VSS.n31 VSS.n30 1.88939
R51 VSS.t4 VSS.n16 1.34879
R52 VSS.n32 VSS.t1 1.25597
R53 VSS.n12 VSS.n24 1.11437
R54 VSS.n26 VSS.n15 131.898
R55 VSS.n31 VSS.n19 1.07558
R56 VSS.n31 VSS.n18 1.07558
R57 VSS.n31 VSS.n17 1.07558
R58 VSS VSS.n33 1.02482
R59 VSS.n12 VSS.t5 1.02198
R60 VSS.n0 VSS.t1 5.28398
R61 VSS.n13 VSS.n12 0.58599
R62 VSS.t5 VSS.n23 0.494495
R63 VSS.n32 VSS.t2 0.472767
R64 VSS.n9 VSS.n22 0.527802
R65 VSS.n24 VSS.n22 0.159554
R66 VSS.n8 VSS.n9 4.1469
R67 VSS.n14 VSS.n27 15.8493
C0 a_414_2612# a_554_348# 0.0231f
C1 a_832_2612# a_554_348# 0.02434f
C2 dw_2768_2744# a_1134_2612# 0.01152f
C3 a_222_2612# a_136_2612# 0.01657f
C4 dw_2768_2744# G 1.15252f
C5 a_222_2612# a_414_2612# 0.01184f
C6 a_136_2612# G 0.01235f
C7 VDD a_2910_379# 0.80967f
C8 a_554_348# VDD 1.56381f
C9 dw_2768_2744# a_136_2612# 0.01068f
C10 a_554_348# a_2910_379# 0.20112f
C11 a_136_2612# a_414_2612# 0.01766f
C12 a_832_2612# dw_2768_2744# 0.0277f
C13 a_832_2612# a_414_2612# 0.02132f
C14 G VDD 4.03849f
C15 dw_2768_2744# VDD 0.35721f
C16 a_554_348# G 1.62443f
C17 a_136_2612# VDD 0.02439f
C18 dw_2768_2744# a_554_348# 0.62961f
C19 a_136_2612# a_554_348# 1.30831f
C20 a_554_348# VSS 13.03152f
C21 a_2910_379# VSS 0.84173f
C22 a_832_2612# VSS 0.31011f
C23 a_414_2612# VSS 0.34892f
C24 a_136_2612# VSS 0.06414f
C25 dw_2768_2744# VSS 2.24702f
C26 VSS.t9 VSS 1.50644f
C27 VSS.t2 VSS 2.35943f
.ends
