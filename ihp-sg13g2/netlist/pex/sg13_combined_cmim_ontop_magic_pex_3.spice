* PEX produced on Thu Jul 23 04:39:20 PM CEST 2026 using /foss/tools/sak/sak-pex.sh with m=3 and s=1 (extresist threshold=10000 mOhm, minres=1000 mOhm, mindelay=1 ps)
* NGSPICE file created from sg13_combined_cmim_ontop_pex.ext - technology: ihp-sg13g2

.subckt sg13_combined_cmim_ontop_pex G VDD VSS
X0 a_554_348# G VSS.t2 VSS.t0 sg13_lv_nmos ad=0.345p pd=2.69u as=0.345p ps=2.69u w=1u l=0.72u
X1 a_136_2612# a_554_348# cap_rfcmim l=7u w=7u
X2 dw_2768_2744# G VSS.t1 VSS.t0 sg13_hv_nmos ad=0.345p pd=2.69u as=0.345p ps=2.69u w=1u l=0.72u
X3 VSS.t4 dw_2768_2744# VSS schottky_nbl1 l=1.2u w=2.655u
X4 a_136_2612# a_554_348# cap_cmim l=20u w=20u
X5 VSS.t9 a_2910_379# dantenna l=0.78u w=0.78u
X6 a_832_2612# dw_2768_2744# VSS.t12 rsil l=0.5u w=0.5u
X7 a_136_2612# a_414_2612# VSS.t11 rhigh l=0.96u w=0.5u
X8 VSS.t5 VSS.t5 a_2910_379# VSS.t6 sg13_hv_nmos ad=0.102p pd=1.28u as=0.102p ps=1.28u w=0.3u l=0.45u
X9 a_2910_379# VDD VDD VDD sg13_hv_pmos ad=0.102p pd=1.28u as=0.102p ps=1.28u w=0.3u l=0.45u
X10 a_414_2612# a_832_2612# VSS.t3 rppd l=0.5u w=0.5u
X11 VSS.t5 VSS.t5 a_2910_379# VSS.t7 sg13_lv_nmos ad=0.1005p pd=1.34u as=0.1005p ps=1.34u w=0.15u l=0.45u
X12 a_2910_379# VDD dpantenna l=0.78u w=0.78u
X13 VDD G a_554_348# VDD sg13_lv_pmos ad=0.345p pd=2.69u as=0.345p ps=2.69u w=1u l=0.72u
X14 a_2910_379# VDD VDD VDD sg13_lv_pmos ad=0.1005p pd=1.34u as=0.1005p ps=1.34u w=0.15u l=0.45u
X15 VDD G dw_2768_2744# VDD sg13_hv_pmos ad=0.345p pd=2.69u as=0.345p ps=2.69u w=1u l=0.72u
R0 VSS.n14 VSS.n24 53631.6
R1 VSS.n28 VSS.n24 19668.2
R2 VSS.n33 VSS.n24 13772.6
R3 VSS.n28 VSS.n16 1589.79
R4 VSS.n30 VSS.t9 1366.25
R5 VSS.t9 VSS.n15 1262.23
R6 VSS.n2 VSS.n26 421.666
R7 VSS.n30 VSS.n28 1049.56
R8 VSS.n30 VSS.n2 232.923
R9 VSS.n1 VSS.n2 254.296
R10 VSS.n11 VSS.n0 29.4996
R11 VSS.t6 VSS.n15 35.0123
R12 VSS.n32 VSS.n11 194.629
R13 VSS.n14 VSS.n13 0.00424718
R14 VSS.n14 VSS.t7 41.615
R15 VSS.n11 VSS.t11 31.7536
R16 VSS.n27 VSS.n25 59.5015
R17 VSS.n13 VSS.n15 0.00202557
R18 VSS.t3 VSS.n0 16.3
R19 VSS.t12 VSS.n0 18.5598
R20 VSS.n16 VSS.n0 0.0892447
R21 VSS.n3 VSS.n26 26.9265
R22 VSS.n1 VSS.n3 7.01496
R23 VSS.n4 VSS.n5 1.17003
R24 VSS.n6 VSS.n19 14.4346
R25 VSS.n4 VSS.n10 1.15693
R26 VSS.n4 VSS.n7 1.15693
R27 VSS.n10 VSS.n23 13.5346
R28 VSS.n7 VSS.n20 13.5346
R29 VSS.n8 VSS.t0 13.5346
R30 VSS.n5 VSS.n23 13.4953
R31 VSS.n9 VSS.t0 13.4953
R32 VSS.n6 VSS.n20 13.4953
R33 VSS.n22 VSS.n5 14.0084
R34 VSS.n27 VSS.n16 10.6391
R35 VSS.n31 VSS.t4 9.34621
R36 VSS.n29 VSS.n18 9.01307
R37 VSS.n32 VSS.n4 1.88993
R38 VSS.n1 VSS.n27 8.5005
R39 VSS.n35 VSS.n23 8.5005
R40 VSS.n35 VSS.t0 8.5005
R41 VSS.n35 VSS.n20 8.5005
R42 VSS.n34 VSS.n10 14.4543
R43 VSS.n9 VSS.n22 14.0084
R44 VSS.n8 VSS.n21 14.0129
R45 VSS.n7 VSS.n21 14.0129
R46 VSS.n31 VSS.n1 1.40772
R47 VSS.t2 VSS.n35 5.28542
R48 VSS.n37 VSS.n36 4.5005
R49 VSS.n0 VSS.n26 789.59
R50 VSS.n0 VSS.n25 4.2505
R51 VSS.n13 VSS.n17 0.868104
R52 VSS.n37 VSS.n18 2.91368
R53 VSS.n17 VSS.t5 0.912672
R54 VSS.n25 VSS.n3 10.7771
R55 VSS.n4 VSS.n9 1.17003
R56 VSS.n4 VSS.n6 1.17003
R57 VSS.n4 VSS.n8 1.15693
R58 VSS.n34 VSS.n33 1.70906
R59 VSS.n32 VSS.n19 1.70906
R60 VSS.t4 VSS.n18 1.34879
R61 VSS.n36 VSS.t1 1.25597
R62 VSS.n12 VSS.n29 1.11437
R63 VSS VSS.n37 1.02482
R64 VSS.n12 VSS.t5 1.02198
R65 VSS.n4 VSS.t1 5.28349
R66 VSS.n33 VSS.n4 1.89479
R67 VSS.n35 VSS.n21 0.628547
R68 VSS.n35 VSS.n22 0.620998
R69 VSS.n13 VSS.n12 0.58599
R70 VSS.n36 VSS.t2 0.472767
R71 VSS.n29 VSS.n17 0.764578
R72 VSS.n35 VSS.n34 0.148951
R73 VSS.n35 VSS.n19 0.148951
R74 VSS.n31 VSS.n0 1.37024
C0 a_136_2612# a_222_2612# 0.01657f
C1 dw_2768_2744# G 1.15252f
C2 dw_2768_2744# VDD 0.35721f
C3 a_832_2612# a_554_348# 0.02434f
C4 a_136_2612# G 0.01235f
C5 a_414_2612# a_222_2612# 0.01184f
C6 VDD a_2910_379# 0.80967f
C7 a_136_2612# VDD 0.02439f
C8 dw_2768_2744# a_1134_2612# 0.01152f
C9 a_414_2612# a_832_2612# 0.02132f
C10 G a_554_348# 1.62443f
C11 VDD a_554_348# 1.56381f
C12 a_136_2612# dw_2768_2744# 0.01068f
C13 dw_2768_2744# a_554_348# 0.62961f
C14 a_554_348# a_2910_379# 0.20112f
C15 a_136_2612# a_554_348# 2.20745f
C16 a_414_2612# a_136_2612# 0.01766f
C17 a_414_2612# a_554_348# 0.0231f
C18 G VDD 4.03849f
C19 dw_2768_2744# a_832_2612# 0.0277f
C20 a_554_348# VSS 18.47362f
C21 a_2910_379# VSS 0.84173f
C22 a_832_2612# VSS 0.31011f
C23 a_414_2612# VSS 0.34892f
C24 a_136_2612# VSS 0.06414f
C25 dw_2768_2744# VSS 2.24702f
C26 VSS.t9 VSS 1.50644f
C27 VSS.t2 VSS 2.35943f
.ends
