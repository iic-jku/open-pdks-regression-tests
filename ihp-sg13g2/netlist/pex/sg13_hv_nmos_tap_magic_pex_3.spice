* PEX produced on Thu Jul 23 04:43:58 PM CEST 2026 using /foss/tools/sak/sak-pex.sh with m=3 and s=1 (extresist threshold=10000 mOhm, minres=1000 mOhm, mindelay=1 ps)
* NGSPICE file created from sg13_hv_nmos_tap_pex.ext - technology: ihp-sg13g2

.subckt sg13_hv_nmos_tap_pex D S B G
X0 S G D B sg13_hv_nmos ad=0.102p pd=1.28u as=0.102p ps=1.28u w=0.3u l=0.45u
C0 S D 0.01855f
C1 S B 0.12724f
C2 D B 0.12724f
.ends
