* PEX produced on Thu Jul 23 04:41:33 PM CEST 2026 using /foss/tools/sak/sak-pex.sh with m=3 and s=1 (extresist threshold=10000 mOhm, minres=1000 mOhm, mindelay=1 ps)
* NGSPICE file created from sg13_combined_wo_rfcmim_pex.ext - technology: ihp-sg13g2

.subckt sg13_combined_wo_rfcmim_pex G VDD VSS
X0 a_554_348# G VSS.t10 VSS.t9 sg13_lv_nmos ad=0.345p pd=2.69u as=0.345p ps=2.69u w=1u l=0.72u
X1 dw_2768_2744# G VSS.t11 VSS.t9 sg13_hv_nmos ad=0.345p pd=2.69u as=0.345p ps=2.69u w=1u l=0.72u
X2 VSS.t0 dw_2768_2744# VSS schottky_nbl1 l=1.2u w=2.655u
X3 VSS.t5 a_2910_379# dantenna l=0.78u w=0.78u
X4 a_832_2612# dw_2768_2744# VSS.t8 rsil l=0.5u w=0.5u
X5 a_136_2612# a_414_2612# VSS.t7 rhigh l=0.96u w=0.5u
X6 a_136_2612# a_554_348# cap_cmim l=20u w=20u
X7 VSS.t1 VSS.t1 a_2910_379# VSS.t2 sg13_hv_nmos ad=0.102p pd=1.28u as=0.102p ps=1.28u w=0.3u l=0.45u
X8 a_2910_379# VDD VDD VDD sg13_hv_pmos ad=0.102p pd=1.28u as=0.102p ps=1.28u w=0.3u l=0.45u
X9 a_414_2612# a_832_2612# VSS.t12 rppd l=0.5u w=0.5u
X10 VSS.t1 VSS.t1 a_2910_379# VSS.t3 sg13_lv_nmos ad=0.1005p pd=1.34u as=0.1005p ps=1.34u w=0.15u l=0.45u
X11 a_2910_379# VDD dpantenna l=0.78u w=0.78u
X12 VDD G a_554_348# VDD sg13_lv_pmos ad=0.345p pd=2.69u as=0.345p ps=2.69u w=1u l=0.72u
X13 a_2910_379# VDD VDD VDD sg13_lv_pmos ad=0.1005p pd=1.34u as=0.1005p ps=1.34u w=0.15u l=0.45u
X14 VDD G dw_2768_2744# VDD sg13_hv_pmos ad=0.345p pd=2.69u as=0.345p ps=2.69u w=1u l=0.72u
R0 VSS.n18 VSS.n16 87518.2
R1 VSS.n18 VSS.n11 24470.6
R2 VSS.n19 VSS.n17 22560
R3 VSS.t8 VSS.n16 16852.7
R4 VSS.t8 VSS.n19 8284.29
R5 VSS.n11 VSS.n17 6273.65
R6 VSS.n19 VSS.n5 2643.38
R7 VSS.n17 VSS.n16 2503.67
R8 VSS.n5 VSS.n11 811.823
R9 VSS.n4 VSS.t5 531.833
R10 VSS.n30 VSS.t8 232.076
R11 VSS.n18 VSS.n3 210.186
R12 VSS.t5 VSS.n18 125.123
R13 VSS.n30 VSS.t12 36.793
R14 VSS.n3 VSS.t2 12.1163
R15 VSS.n23 VSS.t7 33.9628
R16 VSS.t3 VSS.n3 0.00808346
R17 VSS.n8 VSS.n10 17.0005
R18 VSS.n8 VSS.n29 17.0005
R19 VSS.n8 VSS.n20 17.0005
R20 VSS.n8 VSS.n27 17.0005
R21 VSS.n8 VSS.t9 17.0005
R22 VSS.n8 VSS.n25 17.0005
R23 VSS.n8 VSS.n7 0.00185698
R24 VSS.n7 VSS.n6 0.00299949
R25 VSS.n21 VSS.n7 8.50175
R26 VSS.n23 VSS.n6 8.49925
R27 VSS.n22 VSS.n6 17.0005
R28 VSS.n4 VSS.n5 1.48361
R29 VSS.t7 VSS.n21 16.2741
R30 VSS.t12 VSS.n10 12.7363
R31 VSS.n29 VSS.n28 10.1393
R32 VSS.n27 VSS.n26 10.1393
R33 VSS.n24 VSS.t9 10.1393
R34 VSS.n25 VSS.n24 10.1393
R35 VSS.n26 VSS.n20 10.1393
R36 VSS.n28 VSS.n10 10.1393
R37 VSS.n9 VSS.n22 12.309
R38 VSS.n9 VSS.n31 3.25747
R39 VSS.n0 VSS.n1 9.19968
R40 VSS.n8 VSS.n9 0.470602
R41 VSS.n30 VSS.n8 1.88968
R42 VSS.n31 VSS.n10 8.5005
R43 VSS.n8 VSS.n2 0.8598
R44 VSS.n29 VSS.n15 6.32899
R45 VSS.n27 VSS.n14 6.32899
R46 VSS.n25 VSS.n13 6.32899
R47 VSS.n22 VSS.n12 6.32899
R48 VSS.n23 VSS.n12 6.32899
R49 VSS.n21 VSS.n13 6.32899
R50 VSS.t9 VSS.n14 6.32899
R51 VSS.n20 VSS.n15 6.32899
R52 VSS.t10 VSS.n31 5.28542
R53 VSS.n4 VSS.t0 5.2403
R54 VSS.n32 VSS.t10 4.5005
R55 VSS.n2 VSS.t11 4.72532
R56 VSS.n28 VSS.n6 3.43184
R57 VSS.n26 VSS.n6 3.43184
R58 VSS.n24 VSS.n6 3.43184
R59 VSS.n32 VSS.n1 2.91368
R60 VSS.n0 VSS.t1 0.415972
R61 VSS.n31 VSS.n30 1.88939
R62 VSS.t10 VSS.t11 1.72823
R63 VSS.n31 VSS.n15 1.087
R64 VSS.n31 VSS.n14 1.087
R65 VSS.n31 VSS.n13 1.087
R66 VSS.n31 VSS.n12 1.087
R67 VSS VSS.n32 1.02482
R68 VSS.t3 VSS.n0 0.536864
R69 VSS.n2 VSS.n6 1.4897
R70 VSS.t0 VSS.n1 1.17089
C0 dw_2768_2744# a_1134_2612# 0.01152f
C1 a_222_2612# a_136_2612# 0.02105f
C2 dw_2768_2744# G 1.15252f
C3 a_222_2612# a_414_2612# 0.01184f
C4 a_136_2612# G 0.03463f
C5 VDD a_2910_379# 0.80967f
C6 a_554_348# VDD 0.45966f
C7 dw_2768_2744# a_136_2612# 0.16493f
C8 a_554_348# a_2910_379# 0.0696f
C9 a_136_2612# a_414_2612# 0.02635f
C10 a_832_2612# dw_2768_2744# 0.0277f
C11 a_832_2612# a_136_2612# 0.01041f
C12 a_832_2612# a_414_2612# 0.02132f
C13 G VDD 4.03849f
C14 dw_2768_2744# VDD 0.35721f
C15 a_554_348# G 1.20121f
C16 a_136_2612# VDD 0.11039f
C17 dw_2768_2744# a_554_348# 0.01919f
C18 a_136_2612# a_2910_379# 0.0145f
C19 a_136_2612# a_554_348# 1.25672f
C20 a_554_348# VSS 14.9597f
C21 a_2910_379# VSS 0.84173f
C22 a_832_2612# VSS 0.31011f
C23 a_414_2612# VSS 0.34892f
C24 dw_2768_2744# VSS 2.24706f
C25 VSS.t10 VSS 2.35943f
C26 VSS.t5 VSS 1.50652f
.ends
