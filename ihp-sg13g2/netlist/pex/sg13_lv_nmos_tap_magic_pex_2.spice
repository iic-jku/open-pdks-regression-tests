* PEX produced on Thu Jul 23 04:48:13 PM CEST 2026 using /foss/tools/sak/sak-pex.sh with m=2 and s=1
* NGSPICE file created from sg13_lv_nmos_tap_pex.ext - technology: ihp-sg13g2

.subckt sg13_lv_nmos_tap_pex G B D S
X0 S G D B sg13_lv_nmos ad=0.1005p pd=1.34u as=0.1005p ps=1.34u w=0.15u l=0.13u
C0 S D 0.03983f
C1 S B 0.12089f
C2 D B 0.12089f
.ends
