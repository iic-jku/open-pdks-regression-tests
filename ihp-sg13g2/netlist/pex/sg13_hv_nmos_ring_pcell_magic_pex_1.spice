* PEX produced on Thu Jul 23 04:43:27 PM CEST 2026 using /foss/tools/sak/sak-pex.sh with m=1 and s=1
* NGSPICE file created from sg13_hv_nmos_ring_pcell_pex.ext - technology: ihp-sg13g2

.subckt sg13_hv_nmos_ring_pcell_pex B D S G
X0 S G D B sg13_hv_nmos ad=0.102p pd=1.28u as=0.102p ps=1.28u w=0.3u l=0.45u
C0 S B 0.14233f
C1 D B 0.14233f
.ends
