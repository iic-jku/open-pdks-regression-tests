* PEX produced on Thu Jul 23 04:54:03 PM CEST 2026 using /foss/tools/sak/sak-pex.sh with m=2 and s=1
* NGSPICE file created from sg13_schottky_nbl1_pex.ext - technology: ihp-sg13g2

.subckt sg13_schottky_nbl1_pex B C A
X0 A C B schottky_nbl1 l=1.2u w=2.655u
C0 A C 0.41747f
C1 C B 1.1359f
.ends
