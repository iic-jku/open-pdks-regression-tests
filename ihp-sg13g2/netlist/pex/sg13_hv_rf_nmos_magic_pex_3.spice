* PEX produced on Thu Jul 23 04:46:06 PM CEST 2026 using /foss/tools/sak/sak-pex.sh with m=3 and s=1 (extresist threshold=10000 mOhm, minres=1000 mOhm, mindelay=1 ps)
* NGSPICE file created from sg13_hv_rf_nmos_pex.ext - technology: ihp-sg13g2

.subckt sg13_hv_rf_nmos_pex D S G B
X0 D G S B sg13_hv_nmos ad=0.345p pd=2.69u as=0.345p ps=2.69u w=1u l=0.72u
C0 S G 0.30633f
C1 S D 0.08001f
C2 G D 0.30633f
C3 D B 0.72f
C4 S B 0.72f
.ends
