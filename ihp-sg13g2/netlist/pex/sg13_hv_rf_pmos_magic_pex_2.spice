* PEX produced on Thu Jul 23 04:46:37 PM CEST 2026 using /foss/tools/sak/sak-pex.sh with m=2 and s=1
* NGSPICE file created from sg13_hv_rf_pmos_pex.ext - technology: ihp-sg13g2

.subckt sg13_hv_rf_pmos_pex B G D S
X0 D G S B sg13_hv_pmos ad=0.345p pd=2.69u as=0.345p ps=2.69u w=1u l=0.72u
C0 B G 1.28855f
C1 D B 0.02748f
C2 S B 0.02748f
C3 D G 0.30633f
C4 S G 0.30633f
C5 D S 0.08001f
C6 D sub 0.0484f
C7 S sub 0.0484f
C8 B sub 0.40489f
.ends
