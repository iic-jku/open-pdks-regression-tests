* PEX produced on Thu Jul 23 04:51:37 PM CEST 2026 using /foss/tools/sak/sak-pex.sh with m=3 and s=1 (extresist threshold=10000 mOhm, minres=1000 mOhm, mindelay=1 ps)
* NGSPICE file created from sg13_rf_cmim_pex.ext - technology: ihp-sg13g2

.subckt sg13_rf_cmim_pex C1 C0 CX
X0 C0 C1 cap_rfcmim l=10u w=10u
C0 C1 C0 1.01437f
C1 C1 CX 4.70126f
.ends
