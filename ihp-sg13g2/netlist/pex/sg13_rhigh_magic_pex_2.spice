* PEX produced on Thu Jul 23 04:52:14 PM CEST 2026 using /foss/tools/sak/sak-pex.sh with m=2 and s=1
* NGSPICE file created from sg13_rhigh_pex.ext - technology: ihp-sg13g2

.subckt sg13_rhigh_pex R0 R1
X0 R0 R1 sub rhigh l=0.96u w=0.5u
C0 R0 R1 0.01245f
C1 a_122_40# R1 0.01184f
C2 a_122_40# R0 0.01184f
C3 R1 sub 0.18156f
C4 R0 sub 0.18156f
.ends
