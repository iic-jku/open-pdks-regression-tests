* PEX produced on Thu Jul 23 04:52:51 PM CEST 2026 using /foss/tools/sak/sak-pex.sh with m=3 and s=1 (extresist threshold=10000 mOhm, minres=1000 mOhm, mindelay=1 ps)
* NGSPICE file created from sg13_rppd_pex.ext - technology: ihp-sg13g2

.subckt sg13_rppd_pex R0 R1
X0 R0 R1 w_36_40# rppd l=0.5u w=0.5u
C0 R0 R1 0.02132f
C1 R1 w_36_40# 0.15431f
C2 R0 w_36_40# 0.15431f
.ends
