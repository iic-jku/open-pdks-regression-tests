* PEX produced on Thu Jul 23 04:40:54 PM CEST 2026 using /foss/tools/sak/sak-pex.sh with m=2 and s=1
* NGSPICE file created from sg13_combined_pex.ext - technology: ihp-sg13g2

.subckt sg13_combined_pex G VDD VSS
X0 a_554_348# G VSS VSS sg13_lv_nmos ad=0.345p pd=2.69u as=0.345p ps=2.69u w=1u l=0.72u
X1 dw_2768_2744# G VSS VSS sg13_hv_nmos ad=0.345p pd=2.69u as=0.345p ps=2.69u w=1u l=0.72u
X2 VSS dw_2768_2744# VSS schottky_nbl1 l=1.2u w=2.655u
X3 VSS a_2910_379# dantenna l=0.78u w=0.78u
X4 a_832_2612# dw_2768_2744# VSS rsil l=0.5u w=0.5u
X5 a_136_2612# a_414_2612# VSS rhigh l=0.96u w=0.5u
X6 a_136_2612# a_554_348# cap_cmim l=20u w=20u
X7 VSS VSS a_2910_379# VSS sg13_hv_nmos ad=0.102p pd=1.28u as=0.102p ps=1.28u w=0.3u l=0.45u
X8 a_2910_379# VDD VDD VDD sg13_hv_pmos ad=0.102p pd=1.28u as=0.102p ps=1.28u w=0.3u l=0.45u
X9 a_136_2612# a_554_348# cap_rfcmim l=10u w=10u
X10 a_414_2612# a_832_2612# VSS rppd l=0.5u w=0.5u
X11 VSS VSS a_2910_379# VSS sg13_lv_nmos ad=0.1005p pd=1.34u as=0.1005p ps=1.34u w=0.15u l=0.45u
X12 a_2910_379# VDD dpantenna l=0.78u w=0.78u
X13 VDD G a_554_348# VDD sg13_lv_pmos ad=0.345p pd=2.69u as=0.345p ps=2.69u w=1u l=0.72u
X14 a_2910_379# VDD VDD VDD sg13_lv_pmos ad=0.1005p pd=1.34u as=0.1005p ps=1.34u w=0.15u l=0.45u
X15 VDD G dw_2768_2744# VDD sg13_hv_pmos ad=0.345p pd=2.69u as=0.345p ps=2.69u w=1u l=0.72u
C0 a_136_2612# a_832_2612# 0.01041f
C1 dw_2768_2744# G 1.15252f
C2 a_414_2612# a_222_2612# 0.01184f
C3 a_832_2612# a_414_2612# 0.02132f
C4 dw_2768_2744# a_1134_2612# 0.01152f
C5 a_136_2612# VDD 0.11099f
C6 a_136_2612# a_414_2612# 0.02635f
C7 dw_2768_2744# a_832_2612# 0.0277f
C8 a_136_2612# a_2910_379# 0.0145f
C9 a_136_2612# a_554_348# 2.2996f
C10 a_2910_379# VDD 0.80967f
C11 dw_2768_2744# a_136_2612# 0.16493f
C12 VDD a_554_348# 0.45966f
C13 a_136_2612# G 0.03463f
C14 dw_2768_2744# VDD 0.35721f
C15 a_2910_379# a_554_348# 0.0696f
C16 G VDD 4.03849f
C17 dw_2768_2744# a_554_348# 0.01919f
C18 G a_554_348# 1.20121f
C19 a_136_2612# a_222_2612# 0.02105f
C20 a_554_348# VSS 24.13093f
C21 a_2910_379# VSS 1.21658f
C22 a_832_2612# VSS 0.31011f
C23 a_414_2612# VSS 0.34892f
C24 dw_2768_2744# VSS 4.5906f
.ends
