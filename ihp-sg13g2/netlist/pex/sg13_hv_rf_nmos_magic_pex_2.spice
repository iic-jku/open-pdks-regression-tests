* PEX produced on Thu Jul 23 04:46:05 PM CEST 2026 using /foss/tools/sak/sak-pex.sh with m=2 and s=1
* NGSPICE file created from sg13_hv_rf_nmos_pex.ext - technology: ihp-sg13g2

.subckt sg13_hv_rf_nmos_pex D S G B
X0 D G S B sg13_hv_nmos ad=0.345p pd=2.69u as=0.345p ps=2.69u w=1u l=0.72u
C0 G D 0.30633f
C1 G S 0.30633f
C2 D S 0.08001f
C3 D B 0.7152f
C4 S B 0.7152f
.ends
