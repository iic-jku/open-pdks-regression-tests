* PEX produced on Thu Jul 23 04:42:27 PM CEST 2026 using /foss/tools/sak/sak-pex.sh with m=1 and s=1
* NGSPICE file created from sg13_dpantenna_pex.ext - technology: ihp-sg13g2

.subckt sg13_dpantenna_pex B A
X0 A B dpantenna l=0.78u w=0.78u
C0 B sub 1.12631f
.ends
