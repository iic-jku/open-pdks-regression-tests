* PEX produced on Thu Jul 23 04:40:55 PM CEST 2026 using /foss/tools/sak/sak-pex.sh with m=3 and s=1 (extresist threshold=10000 mOhm, minres=1000 mOhm, mindelay=1 ps)
* NGSPICE file created from sg13_combined_pex.ext - technology: ihp-sg13g2

.subckt sg13_combined_pex G VDD VSS
X0 a_554_348# G VSS.t10 VSS.t9 sg13_lv_nmos ad=0.345p pd=2.69u as=0.345p ps=2.69u w=1u l=0.72u
X1 dw_2768_2744# G VSS.t11 VSS.t9 sg13_hv_nmos ad=0.345p pd=2.69u as=0.345p ps=2.69u w=1u l=0.72u
X2 VSS.t0 dw_2768_2744# VSS schottky_nbl1 l=1.2u w=2.655u
X3 VSS.t5 a_2910_379# dantenna l=0.78u w=0.78u
X4 a_832_2612# dw_2768_2744# VSS.t8 rsil l=0.5u w=0.5u
X5 a_136_2612# a_414_2612# VSS.t7 rhigh l=0.96u w=0.5u
X6 a_136_2612# a_554_348# cap_cmim l=20u w=20u
X7 VSS.t1 VSS.t1 a_2910_379# VSS.t2 sg13_hv_nmos ad=0.102p pd=1.28u as=0.102p ps=1.28u w=0.3u l=0.45u
X8 a_2910_379# VDD VDD VDD sg13_hv_pmos ad=0.102p pd=1.28u as=0.102p ps=1.28u w=0.3u l=0.45u
X9 a_136_2612# a_554_348# cap_rfcmim l=10u w=10u
X10 a_414_2612# a_832_2612# VSS.t12 rppd l=0.5u w=0.5u
X11 VSS.t1 VSS.t1 a_2910_379# VSS.t3 sg13_lv_nmos ad=0.1005p pd=1.34u as=0.1005p ps=1.34u w=0.15u l=0.45u
X12 a_2910_379# VDD dpantenna l=0.78u w=0.78u
X13 VDD G a_554_348# VDD sg13_lv_pmos ad=0.345p pd=2.69u as=0.345p ps=2.69u w=1u l=0.72u
X14 a_2910_379# VDD VDD VDD sg13_lv_pmos ad=0.1005p pd=1.34u as=0.1005p ps=1.34u w=0.15u l=0.45u
X15 VDD G dw_2768_2744# VDD sg13_hv_pmos ad=0.345p pd=2.69u as=0.345p ps=2.69u w=1u l=0.72u
R0 VSS.n28 VSS.n27 27377.8
R1 VSS.n27 VSS.n19 16388.6
R2 VSS.n27 VSS.n26 4347.17
R3 VSS.n23 VSS.n20 2002.13
R4 VSS.n24 VSS.t5 1914.89
R5 VSS.n26 VSS.n11 1144.03
R6 VSS.n19 VSS.n9 759.548
R7 VSS.t5 VSS.n19 455.32
R8 VSS.n11 VSS.t8 447.432
R9 VSS.n24 VSS.n23 338.298
R10 VSS.t12 VSS.t7 205.553
R11 VSS.t7 VSS.n12 205.047
R12 VSS.t8 VSS.t12 178.087
R13 VSS.t2 VSS.n9 33.8631
R14 VSS.n0 VSS.n11 38.2404
R15 VSS.t3 VSS.n9 0.00237229
R16 VSS.n2 VSS.n6 0.621352
R17 VSS.n6 VSS.n17 14.5066
R18 VSS.n2 VSS.n3 0.621352
R19 VSS.n3 VSS.n16 14.5066
R20 VSS.n2 VSS.n5 0.621352
R21 VSS.n5 VSS.n15 14.5066
R22 VSS.n2 VSS.n4 0.621352
R23 VSS.n4 VSS.n14 14.5066
R24 VSS.n2 VSS.n7 0.151811
R25 VSS.n5 VSS.t9 7.26189
R26 VSS.n25 VSS.n22 10.4711
R27 VSS.t0 VSS.n21 9.34621
R28 VSS.n18 VSS.n13 9.01307
R29 VSS.n28 VSS.n2 1.89151
R30 VSS.n10 VSS.t3 0.868082
R31 VSS.n29 VSS.n6 14.9487
R32 VSS.n7 VSS.n14 14.9317
R33 VSS.n4 VSS.n15 14.5073
R34 VSS.t9 VSS.n16 7.24591
R35 VSS.n3 VSS.n17 14.5073
R36 VSS.n7 VSS.n12 1.71212
R37 VSS.n25 VSS.n24 5.66717
R38 VSS.n25 VSS.n20 5.66717
R39 VSS.t10 VSS.n30 5.28542
R40 VSS.n1 VSS.n20 2576.86
R41 VSS.n32 VSS.n31 4.5005
R42 VSS.n10 VSS.n18 0.764339
R43 VSS.n32 VSS.n13 2.91368
R44 VSS.n30 VSS.n12 1.88939
R45 VSS.n26 VSS.n25 1.7285
R46 VSS.n29 VSS.n28 1.70906
R47 VSS.n31 VSS.t11 1.25597
R48 VSS.n25 VSS.n21 1.22839
R49 VSS.n8 VSS.n18 1.11437
R50 VSS VSS.n32 1.02482
R51 VSS.n8 VSS.t1 1.02198
R52 VSS.n22 VSS.n13 1.00307
R53 VSS.n30 VSS.n17 0.628547
R54 VSS.n30 VSS.n16 0.628547
R55 VSS.n30 VSS.n15 0.628547
R56 VSS.n30 VSS.n14 0.628547
R57 VSS.t3 VSS.n8 0.58599
R58 VSS.n1 VSS.n21 0.753023
R59 VSS.n31 VSS.t10 0.472767
R60 VSS.n1 VSS.n0 0.00100242
R61 VSS.t1 VSS.n10 0.912787
R62 VSS.n22 VSS.t0 0.346214
R63 VSS.n2 VSS.t11 5.28348
R64 VSS.n30 VSS.n29 0.148951
R65 VSS.n23 VSS.n0 32.9176
C0 dw_2768_2744# a_832_2612# 0.0277f
C1 a_414_2612# a_832_2612# 0.02132f
C2 a_136_2612# a_832_2612# 0.01041f
C3 dw_2768_2744# a_136_2612# 0.16493f
C4 dw_2768_2744# a_1134_2612# 0.01152f
C5 dw_2768_2744# G 1.15252f
C6 a_414_2612# a_136_2612# 0.02635f
C7 VDD dw_2768_2744# 0.35721f
C8 a_2910_379# a_136_2612# 0.0145f
C9 a_136_2612# G 0.03463f
C10 VDD a_2910_379# 0.80967f
C11 VDD a_136_2612# 0.11099f
C12 VDD G 4.03849f
C13 a_414_2612# a_222_2612# 0.01184f
C14 a_222_2612# a_136_2612# 0.02105f
C15 a_554_348# dw_2768_2744# 0.01919f
C16 a_554_348# a_2910_379# 0.0696f
C17 a_554_348# a_136_2612# 2.2996f
C18 a_554_348# G 1.20121f
C19 VDD a_554_348# 0.45966f
C20 a_554_348# VSS 24.18846f
C21 a_2910_379# VSS 0.84173f
C22 a_832_2612# VSS 0.31011f
C23 a_414_2612# VSS 0.34892f
C24 dw_2768_2744# VSS 2.24706f
C25 VSS.t5 VSS 1.50652f
C26 VSS.t10 VSS 2.35943f
.ends
