* PEX produced on Thu Jul 23 04:42:28 PM CEST 2026 using /foss/tools/sak/sak-pex.sh with m=2 and s=1
* NGSPICE file created from sg13_dpantenna_pex.ext - technology: ihp-sg13g2

.subckt sg13_dpantenna_pex B A
X0 A B dpantenna l=0.78u w=0.78u
C0 B A 0.11663f
C1 B sub 0.41283f
.ends
